pzNetwork

.param
+ R_a={10}
+ G_0={1m}
+ R_b={100}
+ R_c={2k}
+ R_d={50}
+ L={1m}
+ C_a={1u}
+ C_b={1n}
+ tau={10u}
+ L={1m}

.source V1
.detector V_1 V_2

V1 4 0 V value={0}
R1 4 5 R value={R_a}
R2 2 0 R value={R_b}
R3 3 0 R value={R_c}
R4 6 0 R value={R_d}
C1 1 6 C value={C_a}
C2 2 0 C value={C_b}
G1 3 0 5 4 G value={G_0/(1+s*tau)}
L1 5 1 L value={L}

.end
