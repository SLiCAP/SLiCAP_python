myPassiveNetwork

.param
+ R_s={50}
+ R_ell={450}
+ C_a={25n}
+ C_b={1/((2*pi*f_s)^2*L)}
+ f_s={5M}
+ S_v={4a}
+ V_DC={5}
+ sigma_V={0.05}
+ sigma_R1={0.02}
+ sigma_R2={0.01}
+ a={2M*pi}
+ L={1u}

.source V1
.detector V_out

C2 out 0 C value={C_a}
C1 2 out C value={C_b}
L1 2 out L value={L}
R2 out 0 R value={R_ell} dcvar={sigma_R2^2} noisetemp={T}
R1 2 1 R value={R_s} dcvar={sigma_R1^2} noisetemp={T}
V1 1 0 V value={a/(a^2+s^2)} dc={V_DC} dcvar={(sigma_V*V_DC)^2} noise={S_v}

.end
