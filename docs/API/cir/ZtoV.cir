ZtoV

.model myOpAmp OV
+ av={A_0/(1+s/(2*pi*p_1))}
+ zo={R_o}

.param
+ R_s={50}

.source V1
.detector V_out
.lgref E_O1

V1 2 0 V value={0}
O2 1 5 3 0 myOpAmp
O1 0 4 out 0 myOpAmp
R2 2 1 R value={R_s}
R4 3 5 R value={(A_1 - 1)*R_a}
R6 5 0 R value={R_a}
R3 3 4 R value={R_b}
R5 4 out R value={A_2*R_b}
R1 1 out R value={R_f}

.end
