balancedNetwork

I1 0 1 I value={I_s}
V1P inP 1 V value={V_a}
V1N inN 1 V value={V_b}
R1P outP inP R value={R_a}
R2P outP LP R value={R_b}
R1N inN outN R value={R_a}
R2N LN outN R value={R_b}
R5 2 0 R value={R_c}
C1 2 0 C value={C_a}
L1P LP 2 L value={L_a}
L1N LN 2 L value={L_a}
K1 L1P L1N K value={k_c}

.end
