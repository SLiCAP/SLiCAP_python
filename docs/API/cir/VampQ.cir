VampQ

.model myQ1 QV
+ cpi={c_pi_1}
+ cbc={c_mu_1}
+ gpi={g_m_1/beta_AC_1}
+ gm={g_m_1}
+ go={g_o_1}

.model myQ2 QV
+ cpi={c_pi_2}
+ cbc={c_mu_2}
+ gpi={g_m_2/beta_AC_2}
+ gm={g_m_2}
+ go={g_o_2}

.source V1
.detector V_L
.lgref Gm_Q2

Q2 L 1 0 0 myQ2
Q1 1 in 2 2 myQ1
C1 L 0 C value={C_L}
R4 L 0 R value={R_L}
R3 2 0 R value={R_b}
R2 L 2 R value={R_a}
R1 in 3 R value={R_s}
V1 3 0 V value={0}

.end
