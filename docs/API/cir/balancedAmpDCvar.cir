balancedAmpDCvar

.param
+ R_a={100k}
+ R_b={100}
+ R_s={1k}
+ R_L={200}
+ f_p1={50}
+ Lot_1={sigma_L^2}

.source V1P V1N
.detector V_outP V_outN

V1N srcN 0 V value={0}
V1P srcP 0 V value={0}
R4 outP outN R value={R_L}
R2N fbN outN R value={R_a} dcvar={sigma_R^2} dcvarlot={Lot_1}
R2P outP fbP R value={R_a} dcvar={sigma_R^2} dcvarlot={Lot_1}
R3 fbP fbN R value={R_b} dcvar={sigma_R^2}
R1N srcN inN R value={R_s}
R1P srcP inP R value={R_s}
X1P inP fbP outP 0 O_dcvar svo={sigma_vo} sio={sigma_io} iib={I_b} sib={sigma_ib}
X1N inN fbN outN 0 O_dcvar svo={sigma_vo} sio={sigma_io} iib={I_b} sib={sigma_ib}
E1 1 0 outN 0 E value={0.5}
E2 comm 1 outP 0 E value={0.5}

.end
