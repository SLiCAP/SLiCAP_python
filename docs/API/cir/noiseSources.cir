noiseSources

V1 2 0 V value={0} noise={S_v}
R1 1 2 R value={R_a} noisetemp={T} noiseflow={f_ell}
L1 1 out L value={L_a}
C1 out 0 C value={C_a}
I1 0 out I value={0} noise={S_i}

.end
