mainAmp

.lib lib/bigAmp.slicap_lib

.param
+ V_s={1}
+ R_s={50}
+ R={50}

V1 1 0 V value={V_s}
R1 2 1 R value={R_s}
R2 3 0 R value={R_L}
X1 0 2 0 3 bigAmp A_i={A_i} R_o={R}

.end
